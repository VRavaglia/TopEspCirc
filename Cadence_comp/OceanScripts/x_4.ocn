simulator( 'spectre )
design(	 "/home/netware/users/raposo/simulation/Comparador/spectre/schematic/netlist/netlist")
resultsDir( "/home/netware/users/raposo/simulation/Comparador/spectre/schematic" )
modelFile(
    '("/home/netware/users/raposo/cadence_umc_update/_G-01-MIXED_MODE-RFCMOS18-1.8V-3.3V-1P6M-MMC/Designkits/Cadence_IC6/UMC_18_CMOS/../Models/Spectre/mm180_bjt_v121.lib.scs" "tt_bip")
    '("/home/netware/users/raposo/cadence_umc_update/_G-01-MIXED_MODE-RFCMOS18-1.8V-3.3V-1P6M-MMC/Designkits/Cadence_IC6/UMC_18_CMOS/../Models/Spectre/mm180_mimcap_v101.lib.scs" "mimcaps_typ")
    '("/home/netware/users/raposo/cadence_umc_update/_G-01-MIXED_MODE-RFCMOS18-1.8V-3.3V-1P6M-MMC/Designkits/Cadence_IC6/UMC_18_CMOS/../Models/Spectre/mm180_reg18bpw_v123.lib.scs" "tt")
    '("/home/netware/users/raposo/cadence_umc_update/_G-01-MIXED_MODE-RFCMOS18-1.8V-3.3V-1P6M-MMC/Designkits/Cadence_IC6/UMC_18_CMOS/../Models/Spectre/mm180_reg33bpw_v123.lib.scs" "tt")
    '("/home/netware/users/raposo/cadence_umc_update/_G-01-MIXED_MODE-RFCMOS18-1.8V-3.3V-1P6M-MMC/Designkits/Cadence_IC6/UMC_18_CMOS/../Models/Spectre/mm180_res_v142.lib.scs" "tt")
    '("/home/netware/users/raposo/cadence_umc_update/_G-01-MIXED_MODE-RFCMOS18-1.8V-3.3V-1P6M-MMC/Designkits/Cadence_IC6/UMC_18_CMOS/../Models/Spectre/mm180_lvt18_v113.lib.scs" "tt")
    '("/home/netware/users/raposo/cadence_umc_update/_G-01-MIXED_MODE-RFCMOS18-1.8V-3.3V-1P6M-MMC/Designkits/Cadence_IC6/UMC_18_CMOS/../Models/Spectre/mm180_lvt33_v113.lib.scs" "tt")
    '("/home/netware/users/raposo/cadence_umc_update/_G-01-MIXED_MODE-RFCMOS18-1.8V-3.3V-1P6M-MMC/Designkits/Cadence_IC6/UMC_18_CMOS/../Models/Spectre/mm180_reg18_v124.lib.scs" "tt")
    '("/home/netware/users/raposo/cadence_umc_update/_G-01-MIXED_MODE-RFCMOS18-1.8V-3.3V-1P6M-MMC/Designkits/Cadence_IC6/UMC_18_CMOS/../Models/Spectre/mm180_reg33_v114.lib.scs" "tt")
    '("/home/netware/users/raposo/cadence_umc_update/_G-01-MIXED_MODE-RFCMOS18-1.8V-3.3V-1P6M-MMC/Designkits/Cadence_IC6/UMC_18_CMOS/../Models/Spectre/mm180_zvt18_v121.lib.scs" "tt")
    '("/home/netware/users/raposo/cadence_umc_update/_G-01-MIXED_MODE-RFCMOS18-1.8V-3.3V-1P6M-MMC/Designkits/Cadence_IC6/UMC_18_CMOS/../Models/Spectre/mm180_zvt33_v113.lib.scs" "tt")
    '("/home/netware/users/raposo/cadence_umc_update/_G-01-MIXED_MODE-RFCMOS18-1.8V-3.3V-1P6M-MMC/Designkits/Cadence_IC6/UMC_18_CMOS/../Models/Spectre/core_rf_v2d4.lib.scs" "tt")
    '("/home/netware/users/raposo/cadence_umc_update/_G-01-MIXED_MODE-RFCMOS18-1.8V-3.3V-1P6M-MMC/Designkits/Cadence_IC6/UMC_18_CMOS/../Models/Spectre/io_rf_v2d3.lib.scs" "tt")
    '("/home/netware/users/raposo/cadence_umc_update/_G-01-MIXED_MODE-RFCMOS18-1.8V-3.3V-1P6M-MMC/Designkits/Cadence_IC6/UMC_18_CMOS/../Models/Spectre/l_slcr20k_rf_v2d3.lib.scs" "typ")
    '("/home/netware/users/raposo/cadence_umc_update/_G-01-MIXED_MODE-RFCMOS18-1.8V-3.3V-1P6M-MMC/Designkits/Cadence_IC6/UMC_18_CMOS/../Models/Spectre/mimcapm_rf_v2d3.lib.scs" "typ")
    '("/home/netware/users/raposo/cadence_umc_update/_G-01-MIXED_MODE-RFCMOS18-1.8V-3.3V-1P6M-MMC/Designkits/Cadence_IC6/UMC_18_CMOS/../Models/Spectre/pad_rf_v2d3.lib.scs" "typ")
    '("/home/netware/users/raposo/cadence_umc_update/_G-01-MIXED_MODE-RFCMOS18-1.8V-3.3V-1P6M-MMC/Designkits/Cadence_IC6/UMC_18_CMOS/../Models/Spectre/rnhr_rf_v2d4.lib.scs" "typ")
    '("/home/netware/users/raposo/cadence_umc_update/_G-01-MIXED_MODE-RFCMOS18-1.8V-3.3V-1P6M-MMC/Designkits/Cadence_IC6/UMC_18_CMOS/../Models/Spectre/rnnpo_rf_v2d4.lib.scs" "typ")
    '("/home/netware/users/raposo/cadence_umc_update/_G-01-MIXED_MODE-RFCMOS18-1.8V-3.3V-1P6M-MMC/Designkits/Cadence_IC6/UMC_18_CMOS/../Models/Spectre/rnppo_rf_v2d4.lib.scs" "typ")
    '("/home/netware/users/raposo/cadence_umc_update/_G-01-MIXED_MODE-RFCMOS18-1.8V-3.3V-1P6M-MMC/Designkits/Cadence_IC6/UMC_18_CMOS/../Models/Spectre/vardiop_rf_v2d3.lib.scs" "typ")
    '("/home/netware/users/raposo/cadence_umc_update/_G-01-MIXED_MODE-RFCMOS18-1.8V-3.3V-1P6M-MMC/Designkits/Cadence_IC6/UMC_18_CMOS/../Models/Spectre/varmis_18_rf_v2d3.lib.scs" "typ")
    '("/home/netware/users/raposo/cadence_umc_update/_G-01-MIXED_MODE-RFCMOS18-1.8V-3.3V-1P6M-MMC/Designkits/Cadence_IC6/UMC_18_CMOS/../Models/Spectre/mm180_diode_v113.mdl.scs" "")
)

analysis('tran ?stop "0.3"  )
desVar( "Ln" 3599.5n )
desVar( "Lp" 1850.8999999999999n )
desVar( "Wn" 2950.0n )
desVar( "Wp" 2601.2n )
desVar( "Vbias" 1.2 )
envOption(
	'analysisOrder  list("tran")
)
option( ?categ 'turboOpts
	'apsplus  t
	'uniModeSpectreX  "APS"
	'uniMode  "APS"
)
temp( 27 )
run()
selectResult( 'tran )
ocnPrint(?output "./SimulationOutputs/vout_4.txt" v("/Vout"))
ocnPrint(?output "./SimulationOutputs/vin_4.txt" v("/Vin"))
ocnPrint(?output "./SimulationOutputs/vcomp_4.txt" v("/Vcomp"))
;exit()
